* p-TFT Id-Vg Transfer Characteristics (Verilog-A OSDI)
.model mt1 ptft_fit W=20u L=4u VT0=0.8000 U0=50.000 SS=0.3500 GOFF=1.0000e-14 POL=1

Vd d 0 -10.0
Vg g 0 0.0
Vs s 0 0.0

N1 d g s mt1

.control
set num_threads=1
pre_osdi ptft_fit.osdi
dc Vg -12.0 2.0 0.2
set wr_singlescale
set wr_vecnames
wrdata out.txt g vd#branch
.endc
.end
