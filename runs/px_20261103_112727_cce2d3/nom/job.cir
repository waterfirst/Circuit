* 8T1C LTPO pixel (GW service)
.options abstol=1e-16 reltol=1e-5 vntol=1e-8 method=gear
.model mT1 ptft_fit W=3.0u L=16.0u VT0=1.6000 U0=65.000 SS=0.3000 GOFF=1.0000e-14 POL=1
.model mT2 ptft_fit W=3.0u L=3.0u VT0=1.1000 U0=65.000 SS=0.3000 GOFF=1.0000e-14 POL=1
.model mT3 ptft_fit W=3.0u L=3.5u VT0=0.5000 U0=15.000 SS=0.3000 GOFF=1.0000e-14 POL=-1
.model mT4 ptft_fit W=3.0u L=3.5u VT0=0.5000 U0=15.000 SS=0.3000 GOFF=1.0000e-14 POL=-1
.model mT5 ptft_fit W=3.0u L=3.0u VT0=1.1000 U0=65.000 SS=0.3000 GOFF=1.0000e-14 POL=1
.model mT6 ptft_fit W=3.0u L=3.0u VT0=1.1000 U0=65.000 SS=0.3000 GOFF=1.0000e-14 POL=1
.model mT7 ptft_fit W=3.0u L=3.0u VT0=1.1000 U0=65.000 SS=0.3000 GOFF=1.0000e-14 POL=1
.model mT8 ptft_fit W=3.0u L=3.0u VT0=1.1000 U0=65.000 SS=0.3000 GOFF=1.0000e-14 POL=1
.model oled D(IS=6e-26 N=3 RS=10k)
VELVDD ELVDD 0 4.6
VELVSS ELVSS 0 -3.0
VVINT VINT 0 -3.5
VVOBS VOBS 0 5.5
VDATA DATA 0 3.0
VGI GI 0 PULSE(-7.0 8.0 100.0000u 1.0u 1.0u 299.0000u 8333.3333u)
VGC GC 0 PULSE(-7.0 8.0 500.0000u 1.0u 1.0u 399.0000u 8333.3333u)
VGW GW 0 PULSE(8.0 -7.0 800.0000u 1.0u 1.0u 7.0000u 8333.3333u)
VEM EM 0 PULSE(-7.0 8.0 0.0010u 1.0u 1.0u 1199.0000u 8333.3333u)
VGO GO 0 PULSE(8.0 -7.0 1000.0000u 1.0u 1.0u 149.0000u 8333.3333u)
N_T1 D G S mT1
N_T2 S GW DATA mT2
N_T3 D GC G mT3
N_T4 G GI VINT mT4
N_T5 S EM ELVDD mT5
N_T6 AN EM D mT6
N_T7 AN GO VINT mT7
N_T8 S GO VOBS mT8
Cst ELVDD G 100.0f
Coled AN ELVSS 30.0f
Vsense AN ANO 0
Doled ANO ELVSS oled
.control
set num_threads=1
pre_osdi ptft_fit.osdi
tran 2u 16666.667u 0 10u
set wr_singlescale
set wr_vecnames
wrdata out.txt v(G) v(S) v(D) v(AN) v(GI) v(GC) v(GW) v(EM) v(GO) i(Vsense)
.endc
.end
