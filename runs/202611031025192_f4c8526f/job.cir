* Test RC
Vin in 0 PULSE(0 5 0 1n 1n 10u 20u)
R1 in out 1k
C1 out 0 10n
.tran 100n 20u
.control
set num_threads=1
run
set wr_singlescale
set wr_vecnames
wrdata out.txt v(in) v(out)
.endc
.end
