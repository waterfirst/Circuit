* GW service job: H=4.0000us f=250.0kHz VGH=8.0 VGL=-7.0 clock=continuous frames=2 hold=100.0us output=low_pulse T=25.0C
.model mT1 ptft_fit W=8.0u L=4.5u VT0=1.1000 U0=65.000 SS=0.3000 GOFF=1.0000e-14 POL=1
.model mT2 ptft_fit W=4.0u L=6.0u VT0=1.1000 U0=65.000 SS=0.3000 GOFF=1.0000e-14 POL=1
.model mT3 ptft_fit W=4.0u L=4.5u VT0=1.1000 U0=65.000 SS=0.3000 GOFF=1.0000e-14 POL=1
.model mT4 ptft_fit W=4.0u L=4.5u VT0=1.1000 U0=65.000 SS=0.3000 GOFF=1.0000e-14 POL=1
.model mT5 ptft_fit W=4.0u L=6.0u VT0=1.1000 U0=65.000 SS=0.3000 GOFF=1.0000e-14 POL=1
.model mT6 ptft_fit W=40.0u L=4.5u VT0=1.1000 U0=65.000 SS=0.3000 GOFF=1.0000e-14 POL=1
.model mT7 ptft_fit W=4.0u L=4.5u VT0=1.1000 U0=65.000 SS=0.3000 GOFF=1.0000e-14 POL=1
.model mT8 ptft_fit W=2.0u L=4.5u VT0=1.1000 U0=65.000 SS=0.3000 GOFF=1.0000e-14 POL=1
.subckt gw IN CKA CKB OUT VGH VGL
* TFT lines: N<name> D G S model
N_T1 B CKA IN mT1
N_T2 A B VGH mT2
N_T3 Q VGL B mT3
N_T4 QB B VGH mT4
N_T5 B A QB mT5
N_T6 OUT QB VGH mT6
N_T7 CKB Q OUT mT7
N_T8 QB CKA VGL mT8
C1 A B 1.0p
C2 Q OUT 0.2p
C3 OUT 0 1.0p
.ends
VGH VGH 0 8.0
VGL VGL 0 -7.0
VFLM FLM 0 PWL(0.0000u 8.0 40.0000u 8.0 40.0500u -7.0 43.0000u -7.0 43.0500u 8.0 184.0000u 8.0 184.0500u -7.0 187.0000u -7.0 187.0500u 8.0)
VCLK1 CLK1 0 PWL(0.0000u 8.0 8.0000u 8.0 8.0500u -7.0 11.0000u -7.0 11.0500u 8.0 16.0000u 8.0 16.0500u -7.0 19.0000u -7.0 19.0500u 8.0 24.0000u 8.0 24.0500u -7.0 27.0000u -7.0 27.0500u 8.0 32.0000u 8.0 32.0500u -7.0 35.0000u -7.0 35.0500u 8.0 40.0000u 8.0 40.0500u -7.0 43.0000u -7.0 43.0500u 8.0 48.0000u 8.0 48.0500u -7.0 51.0000u -7.0 51.0500u 8.0 56.0000u 8.0 56.0500u -7.0 59.0000u -7.0 59.0500u 8.0 64.0000u 8.0 64.0500u -7.0 67.0000u -7.0 67.0500u 8.0 72.0000u 8.0 72.0500u -7.0 75.0000u -7.0 75.0500u 8.0 80.0000u 8.0 80.0500u -7.0 83.0000u -7.0 83.0500u 8.0 88.0000u 8.0 88.0500u -7.0 91.0000u -7.0 91.0500u 8.0 96.0000u 8.0 96.0500u -7.0 99.0000u -7.0 99.0500u 8.0 104.0000u 8.0 104.0500u -7.0 107.0000u -7.0 107.0500u 8.0 112.0000u 8.0 112.0500u -7.0 115.0000u -7.0 115.0500u 8.0 120.0000u 8.0 120.0500u -7.0 123.0000u -7.0 123.0500u 8.0 128.0000u 8.0 128.0500u -7.0 131.0000u -7.0 131.0500u 8.0 136.0000u 8.0 136.0500u -7.0 139.0000u -7.0 139.0500u 8.0 144.0000u 8.0 144.0500u -7.0 147.0000u -7.0 147.0500u 8.0 152.0000u 8.0 152.0500u -7.0 155.0000u -7.0 155.0500u 8.0 160.0000u 8.0 160.0500u -7.0 163.0000u -7.0 163.0500u 8.0 168.0000u 8.0 168.0500u -7.0 171.0000u -7.0 171.0500u 8.0 176.0000u 8.0 176.0500u -7.0 179.0000u -7.0 179.0500u 8.0 184.0000u 8.0 184.0500u -7.0 187.0000u -7.0 187.0500u 8.0 192.0000u 8.0 192.0500u -7.0 195.0000u -7.0 195.0500u 8.0 200.0000u 8.0 200.0500u -7.0 203.0000u -7.0 203.0500u 8.0 208.0000u 8.0 208.0500u -7.0 211.0000u -7.0 211.0500u 8.0 216.0000u 8.0 216.0500u -7.0 219.0000u -7.0 219.0500u 8.0 224.0000u 8.0 224.0500u -7.0 227.0000u -7.0 227.0500u 8.0 232.0000u 8.0 232.0500u -7.0 235.0000u -7.0 235.0500u 8.0 240.0000u 8.0 240.0500u -7.0 243.0000u -7.0 243.0500u 8.0 248.0000u 8.0 248.0500u -7.0 251.0000u -7.0 251.0500u 8.0 256.0000u 8.0 256.0500u -7.0 259.0000u -7.0 259.0500u 8.0 264.0000u 8.0 264.0500u -7.0 267.0000u -7.0 267.0500u 8.0 272.0000u 8.0 272.0500u -7.0 275.0000u -7.0 275.0500u 8.0 280.0000u 8.0 280.0500u -7.0 283.0000u -7.0 283.0500u 8.0 288.0000u 8.0 288.0500u -7.0 291.0000u -7.0 291.0500u 8.0 296.0000u 8.0 296.0500u -7.0 299.0000u -7.0 299.0500u 8.0 304.0000u 8.0 304.0500u -7.0 307.0000u -7.0 307.0500u 8.0 312.0000u 8.0 312.0500u -7.0 315.0000u -7.0 315.0500u 8.0 320.0000u 8.0 320.0500u -7.0 323.0000u -7.0 323.0500u 8.0)
VCLK2 CLK2 0 PWL(0.0000u 8.0 4.0000u 8.0 4.0500u -7.0 7.0000u -7.0 7.0500u 8.0 12.0000u 8.0 12.0500u -7.0 15.0000u -7.0 15.0500u 8.0 20.0000u 8.0 20.0500u -7.0 23.0000u -7.0 23.0500u 8.0 28.0000u 8.0 28.0500u -7.0 31.0000u -7.0 31.0500u 8.0 36.0000u 8.0 36.0500u -7.0 39.0000u -7.0 39.0500u 8.0 44.0000u 8.0 44.0500u -7.0 47.0000u -7.0 47.0500u 8.0 52.0000u 8.0 52.0500u -7.0 55.0000u -7.0 55.0500u 8.0 60.0000u 8.0 60.0500u -7.0 63.0000u -7.0 63.0500u 8.0 68.0000u 8.0 68.0500u -7.0 71.0000u -7.0 71.0500u 8.0 76.0000u 8.0 76.0500u -7.0 79.0000u -7.0 79.0500u 8.0 84.0000u 8.0 84.0500u -7.0 87.0000u -7.0 87.0500u 8.0 92.0000u 8.0 92.0500u -7.0 95.0000u -7.0 95.0500u 8.0 100.0000u 8.0 100.0500u -7.0 103.0000u -7.0 103.0500u 8.0 108.0000u 8.0 108.0500u -7.0 111.0000u -7.0 111.0500u 8.0 116.0000u 8.0 116.0500u -7.0 119.0000u -7.0 119.0500u 8.0 124.0000u 8.0 124.0500u -7.0 127.0000u -7.0 127.0500u 8.0 132.0000u 8.0 132.0500u -7.0 135.0000u -7.0 135.0500u 8.0 140.0000u 8.0 140.0500u -7.0 143.0000u -7.0 143.0500u 8.0 148.0000u 8.0 148.0500u -7.0 151.0000u -7.0 151.0500u 8.0 156.0000u 8.0 156.0500u -7.0 159.0000u -7.0 159.0500u 8.0 164.0000u 8.0 164.0500u -7.0 167.0000u -7.0 167.0500u 8.0 172.0000u 8.0 172.0500u -7.0 175.0000u -7.0 175.0500u 8.0 180.0000u 8.0 180.0500u -7.0 183.0000u -7.0 183.0500u 8.0 188.0000u 8.0 188.0500u -7.0 191.0000u -7.0 191.0500u 8.0 196.0000u 8.0 196.0500u -7.0 199.0000u -7.0 199.0500u 8.0 204.0000u 8.0 204.0500u -7.0 207.0000u -7.0 207.0500u 8.0 212.0000u 8.0 212.0500u -7.0 215.0000u -7.0 215.0500u 8.0 220.0000u 8.0 220.0500u -7.0 223.0000u -7.0 223.0500u 8.0 228.0000u 8.0 228.0500u -7.0 231.0000u -7.0 231.0500u 8.0 236.0000u 8.0 236.0500u -7.0 239.0000u -7.0 239.0500u 8.0 244.0000u 8.0 244.0500u -7.0 247.0000u -7.0 247.0500u 8.0 252.0000u 8.0 252.0500u -7.0 255.0000u -7.0 255.0500u 8.0 260.0000u 8.0 260.0500u -7.0 263.0000u -7.0 263.0500u 8.0 268.0000u 8.0 268.0500u -7.0 271.0000u -7.0 271.0500u 8.0 276.0000u 8.0 276.0500u -7.0 279.0000u -7.0 279.0500u 8.0 284.0000u 8.0 284.0500u -7.0 287.0000u -7.0 287.0500u 8.0 292.0000u 8.0 292.0500u -7.0 295.0000u -7.0 295.0500u 8.0 300.0000u 8.0 300.0500u -7.0 303.0000u -7.0 303.0500u 8.0 308.0000u 8.0 308.0500u -7.0 311.0000u -7.0 311.0500u 8.0 316.0000u 8.0 316.0500u -7.0 319.0000u -7.0 319.0500u 8.0 324.0000u 8.0 324.0500u -7.0 327.0000u -7.0 327.0500u 8.0)
X1 FLM CLK1 CLK2 OUT1 VGH VGL gw
X2 OUT1 CLK2 CLK1 OUT2 VGH VGL gw
X3 OUT2 CLK1 CLK2 OUT3 VGH VGL gw
X4 OUT3 CLK2 CLK1 OUT4 VGH VGL gw
X5 OUT4 CLK1 CLK2 OUT5 VGH VGL gw
X6 OUT5 CLK2 CLK1 OUT6 VGH VGL gw
.options method=gear reltol=1e-4 abstol=1e-12 vntol=1e-6 gmin=1e-12
.control
set num_threads=1
pre_osdi ptft_fit.osdi
tran 10n 328.000u 0 20n
set wr_singlescale
set wr_vecnames
wrdata out.txt v(FLM) v(CLK1) v(CLK2) v(OUT1) v(OUT2) v(OUT3) v(OUT4) v(OUT5) v(OUT6) v(x1.a) v(x1.b) v(x1.q) v(x1.qb) v(x2.a) v(x2.b) v(x2.q) v(x2.qb) v(x3.a) v(x3.b) v(x3.q) v(x3.qb) v(x4.a) v(x4.b) v(x4.q) v(x4.qb) v(x5.a) v(x5.b) v(x5.q) v(x5.qb) v(x6.a) v(x6.b) v(x6.q) v(x6.qb)
.endc
.end
